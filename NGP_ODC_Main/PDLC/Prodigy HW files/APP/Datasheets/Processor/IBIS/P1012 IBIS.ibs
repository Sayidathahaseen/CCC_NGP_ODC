| IBIS file /project/p1022_ckt/usr/cpfulker/IBIS/test.ibs generated by
|Viper version: 2008.08.r27
[IBIS Ver]   3.2
[Comment Char]   |_char
[File Name]   P1012_2009_07_23.ibs
[File Rev]   rev0.0
[Date]   Wed Jul 22 14:43:26 2009
[Source]   Generated using: Viper
[Notes]   This is a Preliminary  Release of P1012 Chip IBIS
[Disclaimer]
[Copyright]   Copyright (C) 1998 - 2004 Freescale Semiconductor
|Israel Ltd.
|   P1012
[Component]   P1012
[Manufacturer]   Freescale
[Package]
|   typ   min   max
R_pkg   0.73207   0.18954   0.87441
L_pkg   8.147e-9   3.254e-9   1.137e-8
C_pkg   1.89e-12   1.309e-12   2.603e-12
[Pin]   Signal_name   model_name   R_pin   L_pin   C_pin
F15   AVDD_CORE0   POWER
F16   AVDD_CORE1   POWER
Y10   AVDD_DDR   POWER
V24   AVDD_PLAT   POWER
B24   BVDD   POWER
C12   BVDD   POWER
C14   BVDD   POWER
C16   BVDD   POWER
C22   BVDD   POWER
D18   BVDD   POWER
G20   BVDD   POWER
M29   BVDD_VSEL0   POWER
M27   BVDD_VSEL1   POWER
C27   CVDD   POWER
E25   CVDD   POWER
E27   CVDD   POWER
L28   CVDD_VSEL0   POWER
L27   CVDD_VSEL1   POWER
AH10   FA_VDD   POWER
A2   GVDD   POWER
AA2   GVDD   POWER
AA3   GVDD   POWER
AA5   GVDD   POWER
AA7   GVDD   POWER
AB6   GVDD   POWER
AD5   GVDD   POWER
AD9   GVDD   POWER
AE3   GVDD   POWER
AF4   GVDD   POWER
AG6   GVDD   POWER
AG8   GVDD   POWER
AJ2   GVDD   POWER
B11   GVDD   POWER
B8   GVDD   POWER
C7   GVDD   POWER
C9   GVDD   POWER
D3   GVDD   POWER
E7   GVDD   POWER
F9   GVDD   POWER
G10   GVDD   POWER
H2   GVDD   POWER
K3   GVDD   POWER
K7   GVDD   POWER
L2   GVDD   POWER
L3   GVDD   POWER
L4   GVDD   POWER
N3   GVDD   POWER
N6   GVDD   POWER
P4   GVDD   POWER
R2   GVDD   POWER
U3   GVDD   POWER
V5   GVDD   POWER
W3   GVDD   POWER
Y2   GVDD   POWER
AC21   LVDD   POWER
AC25   LVDD   POWER
AC27   LVDD   POWER
AE23   LVDD   POWER
AF21   LVDD   POWER
AF25   LVDD   POWER
AH27   LVDD   POWER
AH29   LVDD   POWER
Y23   LVDD   POWER
M28   LVDD_VSEL   POWER
K23   OVDD   POWER
L25   OVDD   POWER
N27   OVDD   POWER
P25   OVDD   POWER
U27   OVDD   POWER
Y26   OVDD   POWER
F17   POVDD   POWER
AD14   SDAVDD   POWER
F13   SENSEVDD   POWER
G6   SENSEVDD_RSVD   POWER
AG16   SVDD   POWER
AH13   SVDD   POWER
AH17   SVDD   POWER
AJ11   SVDD   POWER
AJ15   SVDD   POWER
AJ19   SVDD   POWER
C29   USB_PWRFAULT   POWER
K10   VDD   POWER
K11   VDD   POWER
K12   VDD   POWER
K13   VDD   POWER
K14   VDD   POWER
L10   VDD   POWER
M10   VDD   POWER
K15   VDDC   POWER
K16   VDDC   POWER
K17   VDDC   POWER
K18   VDDC   POWER
K19   VDDC   POWER
K20   VDDC   POWER
L20   VDDC   POWER
M20   VDDC   POWER
N10   VDDC   POWER
N20   VDDC   POWER
P10   VDDC   POWER
P20   VDDC   POWER
R10   VDDC   POWER
R20   VDDC   POWER
T10   VDDC   POWER
T20   VDDC   POWER
U10   VDDC   POWER
U20   VDDC   POWER
V10   VDDC   POWER
V20   VDDC   POWER
W10   VDDC   POWER
W20   VDDC   POWER
Y11   VDDC   POWER
Y12   VDDC   POWER
Y18   VDDC   POWER
Y19   VDDC   POWER
Y20   VDDC   POWER
AD13   XVDD   POWER
AD17   XVDD   POWER
AE11   XVDD   POWER
AE19   XVDD   POWER
AF14   XVDD   POWER
AF16   XVDD   POWER
U25   ASLEEP   lvcmos   0.68621   6.181e-9   1.506e-12
AA29   CKSTP_IN0_B   lvcmos   0.70203   8.492e-9   1.878e-12
AB29   CKSTP_IN1_B   lvcmos   0.72781   8.669e-9   1.778e-12
V25   CKSTP_OUT0_B   lvcmos   0.57715   5.193e-9   1.49e-12
Y27   CKSTP_OUT1_B   lvcmos   0.74883   7.729e-9   1.812e-12
T24   CLK_OUT   lvcmos   0.61262   5.478e-9   1.881e-12
AC9   DDRCLK   lvcmos   0.68041   5.721e-9   2.208e-12
T28   DMA1_DACK_B00   lvcmos   0.74044   7.781e-9   1.677e-12
T26   DMA1_DDONE_B00   lvcmos   0.70115   6.586e-9   1.704e-12
Y28   DMA1_DREQ_B00   lvcmos   0.73462   8.369e-9   1.743e-12
T29   DMA2_DACK_B00   lvcmos   0.70095   8.193e-9   1.629e-12
Y29   DMA2_DDONE_B00   lvcmos   0.6871   8.387e-9   1.814e-12
W28   DMA2_DREQ_B00   lvcmos   0.74053   8.099e-9   1.592e-12
AF24   EC_GTX_CLK125   lvcmos   0.78878   8.442e-9   1.73e-12
AD20   EC_MDC   lvcmos   0.65079   6.884e-9   1.636e-12
AJ21   EC_MDIO   lvcmos   0.8038   9.529e-9   1.753e-12
AD10   FA_ANALOG_G_V   lvcmos   0.58147   5.891e-9   1.406e-12
AJ10   FA_ANALOG_PIN   lvcmos   0.77632   9.552e-9   1.838e-12
R28   GPIO00   lvcmos   0.74055   7.847e-9   1.626e-12
R26   GPIO01   lvcmos   0.63869   6.255e-9   1.771e-12
P29   GPIO02   lvcmos   0.76417   8.605e-9   1.593e-12
N24   GPIO03   lvcmos   0.57899   4.533e-9   1.938e-12
U29   GPIO04   lvcmos   0.69953   8.162e-9   1.721e-12
R24   GPIO05   lvcmos   0.57434   4.533e-9   1.948e-12
R29   GPIO06   lvcmos   0.70241   8.3e-9   1.529e-12
R25   GPIO07   lvcmos   0.68285   6.038e-9   1.721e-12
F22   GPIO08   lvcmos   0.6659   6.555e-9   1.892e-12
A24   GPIO09   lvcmos   0.83153   9.997e-9   1.918e-12
A25   GPIO10   lvcmos   0.84136   1.025e-8   1.915e-12
D24   GPIO11   lvcmos   0.77195   8.179e-9   1.883e-12
F23   GPIO12   lvcmos   0.66719   6.715e-9   2.051e-12
E23   GPIO13   lvcmos   0.68327   6.897e-9   1.824e-12
F24   GPIO14   lvcmos   0.68408   6.934e-9   1.952e-12
E24   GPIO15   lvcmos   0.75781   7.632e-9   1.768e-12
W25   HRESET_B   lvcmos   0.68004   5.845e-9   1.54e-12
U24   HRESET_REQ_B   lvcmos   0.57279   4.489e-9   1.755e-12
G27   IIC1_SCL   lvcmos   0.72255   8.035e-9   1.835e-12
H28   IIC1_SDA   lvcmos   0.80448   9.075e-9   1.948e-12
H25   IIC2_SCL   lvcmos   0.73887   7.27e-9   1.653e-12
H26   IIC2_SDA   lvcmos   0.69599   7.409e-9   1.973e-12
L24   IRQ00   lvcmos   0.58525   4.653e-9   2.059e-12
K26   IRQ01   lvcmos   0.66584   6.64e-9   1.696e-12
K29   IRQ02   lvcmos   0.79903   9.207e-9   1.754e-12
N25   IRQ03   lvcmos   0.69976   6.344e-9   1.809e-12
L26   IRQ04   lvcmos   0.7346   7.028e-9   1.483e-12
L29   IRQ05   lvcmos   0.72993   8.34e-9   1.63e-12
K27   IRQ06   lvcmos   0.75473   7.768e-9   1.757e-12
N29   IRQ_OUT_B   lvcmos   0.7208   8.073e-9   1.707e-12
B21   LA16   lvcmos   0.79994   9.262e-9   1.942e-12
A22   LA17   lvcmos   0.82593   9.927e-9   1.934e-12
C21   LA18   lvcmos   0.71906   8.203e-9   2.101e-12
F21   LA19   lvcmos   0.64861   6.063e-9   1.969e-12
E12   LA20   lvcmos   0.64642   6.097e-9   1.701e-12
A21   LA21   lvcmos   0.82289   1.006e-8   1.964e-12
D11   LA22   lvcmos   0.64311   6.922e-9   2e-12
E22   LA23   lvcmos   0.74322   7.396e-9   2.063e-12
F20   LA24   lvcmos   0.61854   5.341e-9   1.598e-12
E21   LA25   lvcmos   0.7576   7.366e-9   2.004e-12
B22   LA26   lvcmos   0.79575   9.189e-9   1.901e-12
F18   LA27   lvcmos   0.62206   5.356e-9   1.555e-12
A23   LA28   lvcmos   0.82359   1.007e-8   1.942e-12
B23   LA29   lvcmos   0.74215   8.897e-9   2.12e-12
C23   LA30   lvcmos   0.79029   8.712e-9   2.113e-12
D23   LA31   lvcmos   0.78056   8.294e-9   2.036e-12
B18   LAD00   lvcmos   0.79279   9.145e-9   1.92e-12
E20   LAD01   lvcmos   0.73697   7.429e-9   2.043e-12
A19   LAD02   lvcmos   0.81687   1.002e-8   1.902e-12
B20   LAD03   lvcmos   0.80222   9.473e-9   1.928e-12
D19   LAD04   lvcmos   0.68903   7.366e-9   1.721e-12
A18   LAD05   lvcmos   0.74731   9.323e-9   1.958e-12
B17   LAD06   lvcmos   0.72363   8.476e-9   1.902e-12
C20   LAD07   lvcmos   0.68874   8.56e-9   1.873e-12
F19   LAD08   lvcmos   0.61035   5.148e-9   1.556e-12
E10   LAD09   lvcmos   0.66275   6.506e-9   1.765e-12
B16   LAD10   lvcmos   0.71272   8.117e-9   1.874e-12
D14   LAD11   lvcmos   0.73687   7.364e-9   1.796e-12
D17   LAD12   lvcmos   0.6802   7.143e-9   2.009e-12
E11   LAD13   lvcmos   0.70058   6.995e-9   1.931e-12
A16   LAD14   lvcmos   0.79793   9.352e-9   1.889e-12
C15   LAD15   lvcmos   0.69608   7.58e-9   1.821e-12
C17   LALE   lvcmos   0.77207   8.413e-9   1.889e-12
E17   LBCTL   lvcmos   0.70077   6.307e-9   1.627e-12
B15   LCLK00   lvcmos   0.71081   7.997e-9   1.977e-12
A15   LCLK01   lvcmos   0.72947   8.607e-9   1.88e-12
D20   LCS_B00   lvcmos   0.69297   7.482e-9   2.03e-12
A12   LCS_B01   lvcmos   0.79322   9.167e-9   1.711e-12
E19   LCS_B02   lvcmos   0.72916   7.242e-9   1.935e-12
D21   LCS_B03   lvcmos   0.69527   7.545e-9   1.947e-12
F11   LCS_B04   lvcmos   0.58453   4.622e-9   1.818e-12
D15   LCS_B05   lvcmos   0.68398   6.936e-9   1.932e-12
D13   LCS_B06   lvcmos   0.70799   6.655e-9   1.665e-12
A17   LCS_B07   lvcmos   0.8069   9.601e-9   1.772e-12
E18   LDP00   lvcmos   0.71962   7.264e-9   1.799e-12
B19   LDP01   lvcmos   0.79519   9.316e-9   1.876e-12
B12   LGPL0   lvcmos   0.70771   7.973e-9   1.58e-12
C13   LGPL1   lvcmos   0.68392   7.197e-9   1.774e-12
A20   LGPL2   lvcmos   0.75299   9.449e-9   1.889e-12
D10   LGPL3   lvcmos   0.61142   7.09e-9   1.857e-12
B13   LGPL4   lvcmos   0.70611   7.853e-9   1.719e-12
C19   LGPL5   lvcmos   0.70646   7.776e-9   1.877e-12
A13   LSYNC_IN   lvcmos   0.75149   8.11e-9   1.363e-12
A14   LSYNC_OUT   lvcmos   0.68569   7.854e-9   1.517e-12
F12   LWE_B00   lvcmos   0.69609   6.266e-9   1.695e-12
D12   LWE_B01   lvcmos   0.74173   7.549e-9   1.777e-12
L6   MA00   ddr   0.66836   6.75e-9   1.812e-12
M2   MA01   ddr   0.77829   8.24e-9   1.508e-12
M1   MA02   ddr   0.79564   8.854e-9   1.614e-12
M5   MA03   ddr   0.73119   7.48e-9   1.656e-12
N1   MA04   ddr   0.73688   8.579e-9   1.739e-12
P1   MA05   ddr   0.73891   8.788e-9   1.639e-12
N4   MA06   ddr   0.81035   9.192e-9   1.757e-12
P3   MA07   ddr   0.69798   7.602e-9   1.693e-12
P2   MA08   ddr   0.79627   8.424e-9   1.661e-12
R1   MA09   ddr   0.7459   8.821e-9   1.861e-12
K6   MA10   ddr   0.65962   6.468e-9   2.146e-12
R4   MA11   ddr   0.73161   7.462e-9   1.589e-12
T5   MA12   ddr   0.65283   6.59e-9   1.624e-12
J5   MA13   ddr   0.66623   7.115e-9   1.94e-12
T3   MA14   ddr   0.68717   7.587e-9   1.734e-12
U4   MA15   ddr   0.66944   7.235e-9   1.709e-12
N5   MAPAR_ERR_B   ddr   0.75603   7.649e-9   1.675e-12
R5   MAPAR_OUT   ddr   0.66764   6.014e-9   1.87e-12
K5   MBA00   ddr   0.76559   8.004e-9   1.781e-12
L5   MBA01   ddr   0.6656   6.609e-9   1.888e-12
T4   MBA02   ddr   0.7294   7.434e-9   1.556e-12
J3   MCAS_B   ddr   0.77771   8.373e-9   1.687e-12
U2   MCK00   ddr   0.77474   9.27e-9   2.018e-12
AD8   MCK01   ddr   0.68683   7.91e-9   2.407e-12
D4   MCK02   ddr   0.64985   8.011e-9   2.236e-12
T2   MCK03   ddr   0.77199   9.056e-9   1.971e-12
U5   MCKE00   ddr   0.66661   7.17e-9   1.733e-12
V1   MCKE01   ddr   0.78232   9.073e-9   1.503e-12
U1   MCK_B00   ddr   0.71378   8.989e-9   1.935e-12
AD7   MCK_B01   ddr   0.62616   7.528e-9   2.603e-12
D5   MCK_B02   ddr   0.73138   8.547e-9   2.185e-12
T1   MCK_B03   ddr   0.71421   8.817e-9   1.982e-12
AA27   MCP0_B   ddr   0.76201   8.05e-9   1.711e-12
M25   MCP1_B   ddr   0.71644   5.981e-9   1.48e-12
J2   MCS_B00   ddr   0.73431   8.593e-9   1.796e-12
J6   MCS_B01   ddr   0.75299   7.815e-9   1.952e-12
C10   MDIC00   ddr   0.64178   8.113e-9   1.868e-12
F10   MDIC01   ddr   0.65147   6.691e-9   1.917e-12
AH7   MDM00   ddr   0.73049   8.801e-9   1.847e-12
AE7   MDM01   ddr   0.69266   8.149e-9   2.426e-12
AH1   MDM02   ddr   0.85582   1.11e-8   2.299e-12
AC1   MDM03   ddr   0.81243   9.994e-9   1.935e-12
AA4   MDM08   ddr   0.75025   9.645e-9   2.005e-12
AJ8   MDQ00   ddr   0.73635   8.97e-9   2.03e-12
AH8   MDQ01   ddr   0.78727   8.912e-9   1.882e-12
AH5   MDQ02   ddr   0.78598   9.35e-9   1.934e-12
AJ4   MDQ03   ddr   0.71176   9.3e-9   2.107e-12
AJ9   MDQ04   ddr   0.74494   9.319e-9   1.877e-12
AH9   MDQ05   ddr   0.79489   9.129e-9   1.831e-12
AH6   MDQ06   ddr   0.79492   9.138e-9   2.01e-12
AJ5   MDQ07   ddr   0.74682   9.563e-9   2.019e-12
AF8   MDQ08   ddr   0.73062   7.991e-9   1.976e-12
AE8   MDQ09   ddr   0.68457   8.782e-9   2.149e-12
AF5   MDQ10   ddr   0.78906   9.027e-9   2.355e-12
AG4   MDQ11   ddr   0.79396   9.144e-9   2.209e-12
AG9   MDQ12   ddr   0.7496   9.49e-9   1.829e-12
AF9   MDQ13   ddr   0.67688   8.847e-9   2.285e-12
AE6   MDQ14   ddr   0.71782   8.549e-9   2.274e-12
AE5   MDQ15   ddr   0.72398   8.741e-9   2.304e-12
AH3   MDQ16   ddr   0.79308   1.07e-8   2.321e-12
AH2   MDQ17   ddr   0.7996   1.091e-8   2.368e-12
AE1   MDQ18   ddr   0.85014   1.12e-8   2.133e-12
AE2   MDQ19   ddr   0.78796   1.07e-8   2.387e-12
AH4   MDQ20   ddr   0.83951   1.056e-8   2.171e-12
AJ3   MDQ21   ddr   0.86164   1.124e-8   2.234e-12
AF2   MDQ22   ddr   0.79112   1.078e-8   2.272e-12
AF1   MDQ23   ddr   0.85839   1.137e-8   2.238e-12
AD4   MDQ24   ddr   0.73   9.151e-9   2.078e-12
AC4   MDQ25   ddr   0.73949   9.196e-9   2.286e-12
Y5   MDQ26   ddr   0.72358   8.783e-9   2.206e-12
W5   MDQ27   ddr   0.72635   8.882e-9   2.146e-12
AF3   MDQ28   ddr   0.80863   9.925e-9   2.306e-12
AE4   MDQ29   ddr   0.79097   9.324e-9   2.166e-12
AB5   MDQ30   ddr   0.7288   9.088e-9   2.016e-12
Y4   MDQ31   ddr   0.80708   9.431e-9   1.996e-12
AJ6   MDQS00   ddr   0.71054   8.918e-9   2.071e-12
AF6   MDQS01   ddr   0.67709   8.41e-9   2.038e-12
AG2   MDQS02   ddr   0.75248   1.043e-8   2.538e-12
AB3   MDQS03   ddr   0.70028   8.728e-9   2.477e-12
AA1   MDQS08   ddr   0.72363   9.593e-9   2.124e-12
AJ7   MDQS_B00   ddr   0.7841   9.455e-9   2.081e-12
AF7   MDQS_B01   ddr   0.74589   8.738e-9   2.001e-12
AG1   MDQS_B02   ddr   0.81147   1.071e-8   2.397e-12
AB4   MDQS_B03   ddr   0.76303   8.992e-9   2.469e-12
AB1   MDQS_B08   ddr   0.79234   1.014e-8   2.073e-12
M24   MDVAL   ddr   0.58923   4.287e-9   1.852e-12
AD2   MECC00   ddr   0.8181   1.019e-8   1.982e-12
AC2   MECC01   ddr   0.7501   9.546e-9   1.991e-12
W1   MECC02   ddr   0.8177   1.015e-8   1.732e-12
V3   MECC03   ddr   0.78464   9.12e-9   2.059e-12
AB2   MECC04   ddr   0.73582   9.167e-9   1.845e-12
AD1   MECC05   ddr   0.82024   1.032e-8   1.985e-12
Y1   MECC06   ddr   0.81737   1.013e-8   1.719e-12
V6   MECC07   ddr   0.70728   8.533e-9   2.108e-12
H1   MODT00   ddr   0.7336   8.586e-9   1.619e-12
H6   MODT01   ddr   0.74064   7.607e-9   1.952e-12
K1   MRAS_B   ddr   0.80053   9.028e-9   1.555e-12
P28   MSRCID00   ddr   0.7457   7.869e-9   1.61e-12
R27   MSRCID01   ddr   0.72171   7.254e-9   1.607e-12
P27   MSRCID02   ddr   0.66436   6.904e-9   1.813e-12
P26   MSRCID03   ddr   0.65233   6.518e-9   1.738e-12
N26   MSRCID04   ddr   0.72809   6.907e-9   1.733e-12
R6   MVREF   POWER   0.18954   3.254e-9   2.022e-12
K2   MWE_B   ddr   0.77876   8.339e-9   1.608e-12
W26   READY_P1   lvcmos   0.69036   6.373e-9   1.823e-12
K24   RTC   lvcmos   0.6516   6.311e-9   1.96e-12
W27   SCAN_MODE_B   lvcmos   0.63087   6.923e-9   1.834e-12
G29   SDHC_CLK   lvcmos   0.76113   9.525e-9   2.068e-12
F26   SDHC_CMD   lvcmos   0.70757   7.805e-9   2.109e-12
G28   SDHC_DAT00   lvcmos   0.80828   9.345e-9   2.025e-12
F27   SDHC_DAT01   lvcmos   0.79661   8.896e-9   2.075e-12
G25   SDHC_DAT02   lvcmos   0.75199   7.548e-9   1.952e-12
G26   SDHC_DAT03   lvcmos   0.70976   7.747e-9   2.087e-12
AG11   SD_IMP_CAL_RX   rx_pzctl   0.78543   7.085e-9   2.17e-12
AF19   SD_IMP_CAL_TX   tx_pzctl   0.73618   7.111e-9   1.309e-12
AD16   SD_PLL_TPA   opdalg_out 0.70867   5.035e-9   1.792e-12
AE15   SD_PLL_TPD   pouv_out   0.76642   5.653e-9   1.537e-12
AG15   SD_REF_CLK   ptrmr100_cm   0.70173   7.696e-9   1.494e-12
AF15   SD_REF_CLK_B   ptrmr100_cm   0.70982   7.385e-9   1.592e-12
AJ12   SD_RXA_N   ptrmr100_cm   0.75675   8.788e-9   1.587e-12
AH12   SD_RXA_P   ptrmr100_cm   0.75484   8.574e-9   1.649e-12
AJ14   SD_RXB_N   ptrmr100_cm  0.82581   8.5e-9   1.42e-12
AH14   SD_RXB_P   ptrmr100_cm  0.8339   8.384e-9   1.453e-12
AJ16   SD_RXE_N   ptrmr100_cm  0.77677   8.838e-9   1.36e-12
AH16   SD_RXE_P   ptrmr100_cm  0.77226   8.748e-9   1.36e-12
AJ18   SD_RXF_N   ptrmr100_cm  0.73484   8.389e-9   1.583e-12
AH18   SD_RXF_P   ptrmr100_cm  0.73474   8.423e-9   1.575e-12
AE12   SD_TXA_N   lynx_tx   0.76117   6.557e-9   1.467e-12
AD12   SD_TXA_P   lynx_tx   0.74326   6.324e-9   1.43e-12
AF13   SD_TXB_N   lynx_tx   0.68218   6.446e-9   1.321e-12
AE13   SD_TXB_P   lynx_tx   0.68556   6.531e-9   1.323e-12
AF17   SD_TXE_N   lynx_tx   0.66616   6.44e-9   1.514e-12
AE17   SD_TXE_P   lynx_tx   0.6627   6.404e-9   1.576e-12
AE18   SD_TXF_N   lynx_tx   0.74974   6.516e-9   1.438e-12
AD18   SD_TXF_P   lynx_tx   0.74451   6.832e-9   1.368e-12
D29   SPI_CLK   lvcmos   0.8389   1.041e-8   2.018e-12
D28   SPI_CS0_B   lvcmos   0.80402   9.172e-9   2.066e-12
E26   SPI_CS1_B   lvcmos   0.78567   8.427e-9   2.037e-12
F29   SPI_CS2_B   lvcmos   0.78112   9.826e-9   1.998e-12
E29   SPI_CS3_B   lvcmos   0.77372   9.668e-9   2.18e-12
F28   SPI_MISO   lvcmos   0.82473   9.701e-9   2.083e-12
F25   SPI_MOSI   lvcmos   0.68479   7.272e-9   2.544e-12
W24   SRESET_B   lvcmos   0.56937   4.468e-9   1.745e-12
W29   SYSCLK   lvcmos   0.69005   8.267e-9   1.58e-12
V29   TCK   lvcmos   0.76492   8.671e-9   1.519e-12
T25   TDI   lvcmos   0.62074   5.758e-9   1.658e-12
V28   TDO   lvcmos   0.67945   7.477e-9   1.473e-12
E16   TEMP_ANODE   lvcmos   0.64783   6.246e-9   1.766e-12
E15   TEMP_CATHODE   lvcmos   0.69237   6.104e-9   1.375e-12
AA28   TEST_SEL_B   lvcmos   0.69814   7.915e-9   1.859e-12
U26   TMS   lvcmos   0.70119   6.618e-9   1.492e-12
AB28   TRIG_IN   lvcmos   0.71792   8.145e-9   1.872e-12
U28   TRIG_OUT   lvcmos   0.74073   7.818e-9   1.606e-12
V26   TRST_B   lvcmos   0.68987   6.711e-9   1.833e-12
AH26   TSEC1_COL   lvcmos   0.77811   1.002e-8   2.365e-12
AJ27   TSEC1_CRS   lvcmos   0.84458   1.088e-8   2.355e-12
AG25   TSEC1_GTX_CLK   lvcmos   0.83429   9.945e-9   2.194e-12
AH25   TSEC1_RXD00   lvcmos   0.82458   9.732e-9   2.018e-12
AD21   TSEC1_RXD01   lvcmos   0.64276   5.935e-9   1.722e-12
AE22   TSEC1_RXD02   lvcmos   0.76618   7.489e-9   1.938e-12
AJ28   TSEC1_RXD03   lvcmos   0.78385   1.057e-8   2.439e-12
AE24   TSEC1_RXD04   lvcmos   0.69508   7.796e-9   1.941e-12
AJ23   TSEC1_RXD05   lvcmos   0.75061   9.282e-9   1.994e-12
AH22   TSEC1_RXD06   lvcmos   0.80186   9.034e-9   2.07e-12
AG23   TSEC1_RXD07   lvcmos   0.80428   9.046e-9   1.932e-12
AG26   TSEC1_RX_CLK   lvcmos   0.76467   9.373e-9   2.024e-12
AJ26   TSEC1_RX_DV   lvcmos   0.86069   1.096e-8   2.223e-12
AH23   TSEC1_RX_ER   lvcmos   0.81629   9.154e-9   1.878e-12
AD24   TSEC1_TXD00   lvcmos   0.72309   7.699e-9   2.378e-12
AE25   TSEC1_TXD01   lvcmos   0.66267   7.629e-9   2.276e-12
AH28   TSEC1_TXD02   lvcmos   0.72449   9.689e-9   2.102e-12
AJ25   TSEC1_TXD03   lvcmos   0.77167   9.728e-9   1.965e-12
AE21   TSEC1_TXD04   lvcmos   0.73763   7.064e-9   1.555e-12
AD23   TSEC1_TXD05   lvcmos   0.64223   5.846e-9   1.673e-12
AD22   TSEC1_TXD06   lvcmos   0.66624   6.554e-9   1.787e-12
AF22   TSEC1_TXD07   lvcmos   0.68814   7.249e-9   1.533e-12
AJ24   TSEC1_TX_CLK   lvcmos   0.77974   9.996e-9   2.058e-12
AH24   TSEC1_TX_EN   lvcmos   0.76325   9.216e-9   2.037e-12
AF23   TSEC1_TX_ER   lvcmos   0.7922   8.298e-9   1.947e-12
AE27   TSEC2_COL   lvcmos   0.79507   9.179e-9   2.163e-12
AD25   TSEC2_CRS   lvcmos   0.75616   8.217e-9   2.15e-12
AF27   TSEC2_TXD01   lvcmos   0.74049   9.007e-9   2.233e-12
AB25   TSEC2_TXD04   lvcmos   0.6399   6.376e-9   2.214e-12
AB24   TSEC2_TXD05   lvcmos   0.6843   6.572e-9   2.204e-12
AE29   TSEC2_TX_ER   lvcmos   0.76412   9.726e-9   1.933e-12
AE20   TSEC_1588_ALARM_OUT1 lvcmos   0.64816   6.364e-9   1.511e-12
AJ20   TSEC_1588_ALARM_OUT2 lvcmos   0.80647   9.451e-9   1.642e-12
AG21   TSEC_1588_CLK_IN   lvcmos   0.69808   7.651e-9   1.962e-12
AG22   TSEC_1588_CLK_OUT   lvcmos   0.69828   7.824e-9   1.923e-12
AH21   TSEC_1588_PULSE_OUT1 lvcmos   0.79155   8.956e-9   1.886e-12
AJ22   TSEC_1588_PULSE_OUT2 lvcmos   0.81496   9.761e-9   2.045e-12
AH20   TSEC_1588_TRIG_IN1   lvcmos   0.78017   8.865e-9   1.833e-12
AG20   TSEC_1588_TRIG_IN2   lvcmos   0.6921   7.658e-9   1.991e-12
J28   UART_CTS_B00   lvcmos   0.79235   8.882e-9   1.844e-12
H24   UART_CTS_B01   lvcmos   0.67064   7.176e-9   1.916e-12
J29   UART_RTS_B00   lvcmos   0.74834   9.092e-9   1.931e-12
J24   UART_RTS_B01   lvcmos   0.65909   6.747e-9   1.844e-12
H29   UART_SIN00   lvcmos   0.81385   9.578e-9   1.758e-12
G24   UART_SIN01   lvcmos   0.61396   6e-9   2.586e-12
J26   UART_SOUT00   lvcmos   0.75647   7.812e-9   1.794e-12
J25   UART_SOUT01   lvcmos   0.73335   7.158e-9   1.702e-12
J27   UDE0_B   lvcmos   0.69689   7.654e-9   1.8e-12
K28   UDE1_B   lvcmos   0.7809   8.623e-9   1.846e-12
D27   USB_CLK   lvcmos   0.74568   8.498e-9   2.106e-12
C26   USB_D00   lvcmos   0.77366   9.128e-9   2.37e-12
A26   USB_D01   lvcmos   0.85679   1.043e-8   2.025e-12
A27   USB_D02   lvcmos   0.87441   1.103e-8   2.162e-12
D26   USB_D03   lvcmos   0.67536   8.145e-9   2.456e-12
B25   USB_D04   lvcmos   0.75499   9.222e-9   1.988e-12
B28   USB_D05   lvcmos   0.76123   9.907e-9   2.36e-12
C25   USB_D06   lvcmos   0.72221   8.278e-9   2.183e-12
C28   USB_D07   lvcmos   0.79307   9.813e-9   2.324e-12
A28   USB_DIR   lvcmos   0.84636   1.076e-8   1.979e-12
B26   USB_NXT   lvcmos   0.77103   9.467e-9   1.875e-12
B29   USB_STP   lvcmos   0.77428   9.947e-9   2.48e-12
AD15   SDAVSS   GND
P6   SENSEVSS   GND
AG12   SVSS   GND
AG13   SVSS   GND
AG14   SVSS   GND
AG17   SVSS   GND
AG18   SVSS   GND
AG19   SVSS   GND
AH11   SVSS   GND
AH15   SVSS   GND
AH19   SVSS   GND
AJ13   SVSS   GND
AJ17   SVSS   GND
A1   VSS   GND
A29   VSS   GND
AA23   VSS   GND
AA6   VSS   GND
AC10   VSS   GND
AC20   VSS   GND
AC24   VSS   GND
AC28   VSS   GND
AC3   VSS   GND
AD3   VSS   GND
AD6   VSS   GND
AE9   VSS   GND
AF20   VSS   GND
AG24   VSS   GND
AG27   VSS   GND
AG3   VSS   GND
AG5   VSS   GND
AG7   VSS   GND
AJ1   VSS   GND
AJ29   VSS   GND
B14   VSS   GND
B27   VSS   GND
B5   VSS   GND
C11   VSS   GND
C18   VSS   GND
C24   VSS   GND
C6   VSS   GND
C8   VSS   GND
D16   VSS   GND
D22   VSS   GND
D25   VSS   GND
E28   VSS   GND
E3   VSS   GND
F7   VSS   GND
G21   VSS   GND
G5   VSS   GND
G9   VSS   GND
H27   VSS   GND
H3   VSS   GND
J23   VSS   GND
J7   VSS   GND
K25   VSS   GND
K4   VSS   GND
L1   VSS   GND
L11   VSS   GND
L12   VSS   GND
L13   VSS   GND
L14   VSS   GND
L15   VSS   GND
L16   VSS   GND
L17   VSS   GND
L18   VSS   GND
L19   VSS   GND
M11   VSS   GND
M12   VSS   GND
M13   VSS   GND
M14   VSS   GND
M15   VSS   GND
M16   VSS   GND
M17   VSS   GND
M18   VSS   GND
M19   VSS   GND
M26   VSS   GND
M3   VSS   GND
M4   VSS   GND
M6   VSS   GND
N11   VSS   GND
N12   VSS   GND
N13   VSS   GND
N14   VSS   GND
N15   VSS   GND
N16   VSS   GND
N17   VSS   GND
N18   VSS   GND
N19   VSS   GND
N2   VSS   GND
N28   VSS   GND
P11   VSS   GND
P12   VSS   GND
P13   VSS   GND
P14   VSS   GND
P15   VSS   GND
P16   VSS   GND
P17   VSS   GND
P18   VSS   GND
P19   VSS   GND
P24   VSS   GND
P5   VSS   GND
R11   VSS   GND
R12   VSS   GND
R13   VSS   GND
R14   VSS   GND
R15   VSS   GND
R16   VSS   GND
R17   VSS   GND
R18   VSS   GND
R19   VSS   GND
R3   VSS   GND
T11   VSS   GND
T12   VSS   GND
T13   VSS   GND
T14   VSS   GND
T15   VSS   GND
T16   VSS   GND
T17   VSS   GND
T18   VSS   GND
T19   VSS   GND
T27   VSS   GND
T6   VSS   GND
U11   VSS   GND
U12   VSS   GND
U13   VSS   GND
U14   VSS   GND
U15   VSS   GND
U16   VSS   GND
U17   VSS   GND
U18   VSS   GND
U19   VSS   GND
V11   VSS   GND
V12   VSS   GND
V13   VSS   GND
V14   VSS   GND
V15   VSS   GND
V16   VSS   GND
V17   VSS   GND
V18   VSS   GND
V19   VSS   GND
V27   VSS   GND
V4   VSS   GND
W11   VSS   GND
W12   VSS   GND
W13   VSS   GND
W14   VSS   GND
W15   VSS   GND
W16   VSS   GND
W17   VSS   GND
W18   VSS   GND
W19   VSS   GND
W2   VSS   GND
W4   VSS   GND
Y13   VSS   GND
Y17   VSS   GND
Y25   VSS   GND
Y3   VSS   GND
Y6   VSS   GND
Y7   VSS   GND
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| Diff Pairs
[Diff pin]   inv_pin   vdiff   tdelay_typ   tdelay_min   tdelay_max
|   MCK Signals
   U2   U1   250mV   0ns   NA   NA
   AD8   AD7   250mV   0ns   NA   NA
   D4   D5   250mV   0ns   NA   NA
   T2   T1   250mV   0ns   NA   NA
|   MDQS Signals: Use this format to arrange MDQS signals for
|   differential operation.  To use MDQS as
|   single-ended operation, comment out the following
|   nine lines.
   AJ6   AJ7   250mV   0ns   NA   NA
   AF6   AF7   250mV   0ns   NA   NA
   AG2   AG1   250mV   0ns   NA   NA
   AB3   AB4   250mV   0ns   NA   NA
   AA1   AB1   250mV   0ns   NA   NA
|   SD_TX(3:0)
   AD18   AE18   NA   NA   NA   NA
   AE17   AF17   NA   NA   NA   NA
   AE13   AF13   NA   NA   NA   NA
   AD12   AE12   NA   NA   NA   NA
|   SD_RX(3:0)
   AH18   AJ18   NA   NA   NA   NA
   AH16   AJ16   NA   NA   NA   NA
   AH14   AJ14   NA   NA   NA   NA
   AH12   AJ12   NA   NA   NA   NA
|   SD_REF_CLK
   AG15   AF15   NA   NA   NA   NA
|*   Model Selector   *
[Model Selector] ddr
ddr2_rcvr_150   DDR2 receiver with odt = 150 ohms
ddr2_rcvr_50   DDR2 receiver with odt =  50 ohms
ddr2_rcvr_75   DDR2 receiver with odt =  75 ohms
ddr2_rcvr_noterm   DDR2 receiver with no odt
ddr3_rcvr_120   DDR3 receiver with odt = 120 ohms
ddr3_rcvr_60   DDR3 receiver with odt = 60 ohms
ddr3_rcvr_noterm   DDR3 receiver with no odt
ddr2_drvr_18   DDR2 driver - 18 Ohm
ddr2_drvr_35   DDR2 driver - 35 Ohm
ddr3_drvr_17   DDR3 driver - 17 Ohm
ddr3_drvr_40   DDR23driver - 40 Ohm
[Model Selector] lvcmos
v180_in_wb   LVCMOS 1.8V Receiver
v250_in_wb   LVCMOS 2.5V Receiver
v330_in_wb   LVCMOS 3.3V Receiver
v180_wb   LVCMOS 1.8V IO
v250_wb   LVCMOS 2.5V IO
v330_wb   LVCMOS 3.3V IO
[Model Selector] lynx_tx
sd45_ohsdr100_x_004p   lynx model
sd45_ohsdr100_x_004s   lynx model
sd45_ohsdr100_x_006p   lynx model
sd45_ohsdr100_x_006s   lynx model
sd45_ohsdr100_x_303   lynx model
sd45_ohsdr100_x_304   lynx model
sd45_ohsdr100_x_403   lynx model
sd45_ohsdr100_x_404   lynx model
sd45_ohsdr100_x_502   lynx model
sd45_ohsdr100_x_503   lynx model
sd45_ohsdr100_x_602   lynx model
sd45_ohsdr100_x_603   lynx model
| Models and submodels in the file (49): ddr2_drvr_18 (I/O), ddr2_drvr_35 (I/O), ddr2_rcvr_150 (Input), ddr2_rcvr_50 (Input), ddr2_rcvr_75 (Input), ddr2_rcvr_noterm (Input), ddr3_drvr_17 (I/O), ddr3_drvr_40 (I/O), ddr3_rcvr_120 (Input), ddr3_rcvr_60 (Input), ddr3_rcvr_noterm (Input), opdalg_out (Output), pouv_out (3-state), v180_in_wb (Input), v330_in_wb (Input), v250_wb (I/O), v250_in_wb (Input), v180_wb (I/O), v330_wb (I/O), ptrmr100_cm (Input), rx_pzctl (Input), sd45_ohsdr100_x_004p (3-state), sd45_ohsdr100_x_004s (3-state), sd45_ohsdr100_x_006p (3-state), sd45_ohsdr100_x_006s (3-state), sd45_ohsdr100_x_304 (3-state), sd45_ohsdr100_x_303 (3-state), sd45_ohsdr100_x_403 (3-state), sd45_ohsdr100_x_502 (3-state), sd45_ohsdr100_x_503 (3-state), sd45_ohsdr100_x_602 (3-state), sd45_ohsdr100_x_603 (3-state), sd45_ohsdr100_x_00 (3-state), sd45_ohsdr100_x_04 (3-state), sd45_ohsdr100_x_06 (3-state), sd45_ohsdr100_x_30 (3-state), sd45_ohsdr100_x_33 (3-state), sd45_ohsdr100_x_34 (3-state), sd45_ohsdr100_x_40 (3-state), sd45_ohsdr100_x_43 (3-state), sd45_ohsdr100_x_44 (3-state), sd45_ohsdr100_x_50 (3-state), sd45_ohsdr100_x_52 (3-state), sd45_ohsdr100_x_53 (3-state), sd45_ohsdr100_x_60 (3-state), sd45_ohsdr100_x_62 (3-state), sd45_ohsdr100_x_63 (3-state), tx_pzctl (Input), sd45_ohsdr100_x_404 (3-state)
